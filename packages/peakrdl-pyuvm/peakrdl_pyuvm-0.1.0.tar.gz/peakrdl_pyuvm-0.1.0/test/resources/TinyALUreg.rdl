addrmap TinyALUreg {
    name = "TinyALUreg";
    desc = "Register description of TinyALU";
    bigendian = true;
    default regwidth = 16;
    hdl_path = "top";

    reg {
        name = "source data reg";
        hdl_path = "srcreg";
        field {
            desc = "source data register 0";
            hw=r; sw=rw;
        } data0[7:0] = 0;

        field {
            desc = "source data register 1";
            hw=r; sw=rw;
        } data1[15:8] = 0;

    } SRC @ 0x0;

    reg {
        name = "result data reg";

        field {
            desc = "result data";
            hw=w; sw=r;
        } data[15:0] = 0;

    } RESULT @ 0x2;

    reg {
        name = "Command and status register";

        field {
            desc = "operation";
            hw=r; sw=rw;
        } op[4:0] = 0;

        field {
            desc = "start";
            hw=r; sw=rw;
        } start[5:5] = 0;

        field {
            desc = "Done";
            hw=w; sw=r;
        } done[6:6] = 0;

        field {
            desc = "reserved field";
            hw=w; sw=rw;
        } reserved[15:7] = 0;

    } CMD @ 0x4;

    reg {
        name = "Test register";

        field {
            desc = "Array of fields";
        } FOO[15:0] = 0;
    } TEST[2][8];

//    external mem {
//        mementries = 1024;
//        memwidth = 32;
//    } IMEM @ 0x1000;

};


addrmap BAR0 {
    name = "Bar 0 register space";
    bigendian = true;
    TinyALUreg ALU0;
    TinyALUreg ALU1[2];
};
